* Class AB push-pull stage crossover inspection.
* The solver should run this native DC transfer sweep and summarize the
* crossover dead zone around 0 V input.

.MODEL Q2N2222A NPN (IS=1E-14 BF=200 VAF=100)
.MODEL Q2N2907A PNP (IS=1E-14 BF=200 VAF=100)

VCC  VCC  0   DC 12
VEE  VEE  0   DC -12

VIN  IN   0   DC 0
R1   IN   BASE 1k

QNPN VCC  BASE NOUT Q2N2222A
QPNP VEE  BASE NOUT Q2N2907A

RL   NOUT 0    8

.DC VIN -100m 100m 10m
.MEAS DC VOUT_N20M FIND V(NOUT) AT=-20m
.MEAS DC VOUT_N10M FIND V(NOUT) AT=-10m
.MEAS DC VOUT_0M   FIND V(NOUT) AT=0
.MEAS DC VOUT_P10M FIND V(NOUT) AT=10m
.MEAS DC VOUT_P20M FIND V(NOUT) AT=20m
.PROBE
.END
