* Mixed-signal transient: RC integrator + Schmitt trigger + 74LS74 DFF
*   VPULSE 100 kHz square -> R(1k) -> C(1nF) node N1
*   Schmitt U1 (74HC14) on N1 -> node SCHM_OUT
*   D input of 74LS74 (U2) tied to SCHM_OUT
*   CLK of 74LS74 from a separate 200 kHz clock
*   PRE and CLR tied HIGH (inactive)
*
* Evaluate Q at t = 1 ms.

VCC  VCC  0  DC 5
VPLS IN   0  PULSE(0 5 0 10n 10n 5u 10u)
VCLK CLK  0  PULSE(0 5 0 10n 10n 2.5u 5u)

R1   IN   N1    1k
C1   N1   0     1n

* Schmitt inverter (ABM stand-in)
E_SCH SCHMT_OUT 0 VALUE {IF(V(N1)>2.5, 0, 5)}

* 74LS74 D-FF (digital; PSpice A/D)
U2   SCHMT_OUT CLK PRE CLR Q QBAR DSTM1 74LS74 IO_STM
XSTD VCC VEE PRE_HI 0 0

VPRE PRE  0 DC 5
VCLR CLR  0 DC 5

.TRAN 10n 1m 0 10n

.MEAS TRAN Q_AT_1MS FIND V(Q) AT=1m
.MEAS TRAN QBAR_AT_1MS FIND V(QBAR) AT=1m
.PROBE

.END
