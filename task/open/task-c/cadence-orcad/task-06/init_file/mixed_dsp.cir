* Native passive low-pass transient task.
* Run the native PSpice transient analysis, keep the generated
* .out/.dat/.measure artifacts, and derive passband / stopband
* attenuation from the measured max/min values.

.PARAM CASE = 1
.PARAM FREQ = {TABLE(CASE, 1,1k, 2,5k)}
.PARAM VINAMP = {TABLE(CASE, 1,1.0, 2,0.5)}

VIN   IN   0    SIN(0 {VINAMP} {FREQ} 0 0)
RSRC  IN   N1   68
R1    N1   N2   1.0k
C1    N2   0    47n
R2    N2   N3   1.5k
C2    N3   0    33n
RL    N3   0    10k

.TRAN 10u 10m 0 10u
.STEP PARAM CASE LIST 1 2
.MEAS TRAN FREQVAL PARAM {FREQ}
.MEAS TRAN VINVAL  PARAM {VINAMP}
.MEAS TRAN VINMAX MAX V(IN) FROM=8m TO=10m
.MEAS TRAN VINMIN MIN V(IN) FROM=8m TO=10m
.MEAS TRAN VOUTMAX MAX V(N3) FROM=8m TO=10m
.MEAS TRAN VOUTMIN MIN V(N3) FROM=8m TO=10m
.PROBE
.END
