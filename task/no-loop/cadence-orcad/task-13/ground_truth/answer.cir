Five-section on-chip RC line
VIN in 0 PULSE(0 1 0 20p 20p 1n 2n)
R1 in n1 20
C1 n1 0 40f
R2 n1 n2 20
C2 n2 0 40f
R3 n2 n3 20
C3 n3 0 40f
R4 n3 n4 20
C4 n4 0 40f
R5 n4 out 20
C5 out 0 40f
.TRAN 1p 3n
.MEASURE TRAN TDELAY TRIG V(in) VAL=0.5 RISE=1 TARG V(out) VAL=0.5 RISE=1
.PROBE V(*) I(*)
.END
