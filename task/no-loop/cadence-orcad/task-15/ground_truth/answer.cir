Three-section local interconnect
VIN in 0 PULSE(0 1 0 20p 20p 1n 2n)
R1 in n1 35
C1 n1 0 20f
R2 n1 n2 35
C2 n2 0 20f
R3 n2 out 35
C3 out 0 20f
.TRAN 1p 3n
.MEASURE TRAN TDELAY TRIG V(in) VAL=0.5 RISE=1 TARG V(out) VAL=0.5 RISE=1
.PROBE V(*) I(*)
.END
