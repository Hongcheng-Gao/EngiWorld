Wire-bond package impedance
IAC 0 pin AC 1
RLEAD pin n1 0.15
LLEAD n1 pad 1.2n
CPAD pad 0 0.25p
RBLEED pad 0 1G
.AC DEC 50 1MEG 20G
.MEASURE AC Z_DB_HIGH FIND DB(V(pin)) AT=20G
.PROBE V(*) I(*)
.END
