High-capacitance pad inverter
VDD vdd 0 3.3
VIN in 0 PULSE(0 3.3 0 0.2n 0.2n 2n 4n)
MN out in 0 0 NCORE W=2u L=0.18u
MP out in vdd vdd PCORE W=4u L=0.18u
CLOAD out 0 80f
.MODEL NCORE NMOS (LEVEL=1 VTO=0.45 KP=220u)
.MODEL PCORE PMOS (LEVEL=1 VTO=-0.45 KP=100u)
.TRAN 5p 12n
.MEASURE TRAN TPHL TRIG V(in) VAL=1.65 RISE=1 TARG V(out) VAL=1.65 FALL=1
.MEASURE TRAN TPLH TRIG V(in) VAL=1.65 FALL=1 TARG V(out) VAL=1.65 RISE=1
.PROBE V(*) I(*)
.END
