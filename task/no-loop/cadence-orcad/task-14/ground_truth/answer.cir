Eight-section global interconnect
VIN in 0 PULSE(0 1 0 20p 20p 1n 2n)
R1 in n1 12
C1 n1 0 65f
R2 n1 n2 12
C2 n2 0 65f
R3 n2 n3 12
C3 n3 0 65f
R4 n3 n4 12
C4 n4 0 65f
R5 n4 n5 12
C5 n5 0 65f
R6 n5 n6 12
C6 n6 0 65f
R7 n6 n7 12
C7 n7 0 65f
R8 n7 out 12
C8 out 0 65f
.TRAN 1p 3n
.MEASURE TRAN TDELAY TRIG V(in) VAL=0.5 RISE=1 TARG V(out) VAL=0.5 RISE=1
.PROBE V(*) I(*)
.END
