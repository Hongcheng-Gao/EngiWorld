Long-channel NMOS threshold sweep
VD d 0 5.0
VG g 0 0
M1 d g 0 0 NMOS_CORE W=10u L=1.0u
.MODEL NMOS_CORE NMOS (LEVEL=1 VTO=0.7 KP=180u LAMBDA=0.03)
.DC VG 0 5.0 0.01
.MEASURE DC ID_MID FIND I(VD) AT=2.5
.PROBE V(*) I(*)
.END
