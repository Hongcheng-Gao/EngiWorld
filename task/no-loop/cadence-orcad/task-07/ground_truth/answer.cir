Silicon diode room-temperature I-V
VD anode 0 0
DUT anode 0 DSI
.MODEL DSI D (IS=1e-14 N=1.05 RS=0.5 CJO=2p TT=5n)
.TEMP 25
.DC VD -1 0.9 0.005
.MEASURE DC I_AT_0P7 FIND I(VD) AT=0.7
.PROBE V(*) I(*)
.END
