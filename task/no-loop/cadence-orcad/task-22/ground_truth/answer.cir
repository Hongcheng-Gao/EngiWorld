Photodiode front-end input pulse
VDRV src 0 PULSE(0 1.8 5n 0.2n 0.2n 100.0n 200n)
RDRV src n1 2
LPKG n1 gate 2.0n
CGATE gate 0 0.8n
RLEAK gate 0 10MEG
.TRAN 0.02n 200n
.MEASURE TRAN VPEAK MAX V(gate)
.PROBE V(*) I(*)
.END
