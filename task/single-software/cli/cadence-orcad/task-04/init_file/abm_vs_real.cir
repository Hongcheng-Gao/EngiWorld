* Comparison: ABM Laplace 2nd-order LPF vs real Sallen-Key op-amp circuit
*
* Run the AC sweep and keep the native .out / _measure.txt / .dat files.
* The task is to compare sampled DB(V(OUT_ABM)) and DB(V(OUT_SK)) values
* from the native measurement file.
*
* Target transfer function:
*   H(s) = 1 / (s*s/w0^2 + s/(Q*w0) + 1)
* with f0 = 10 kHz and Q = 0.707.

VIN   IN   0   AC 1 0

* ---------- ABM path ----------
E_ABM  OUT_ABM  0  LAPLACE { V(IN) } {1/(s*s/3.947842e9 + s/4.443e4 + 1)}

* ---------- Real Sallen-Key path ----------
R_S1  IN      N1      1.59k
R_S2  N1      N2      1.59k
C_S1  N1      OUT_SK  22n
C_S2  N2      0       4.7n
E_SK  OUT_SK  0       N2  OUT_SK  1E6

.AC DEC 20 100 100k
.MEAS AC ABM_100   FIND DB(V(OUT_ABM)) AT=100
.MEAS AC SK_100    FIND DB(V(OUT_SK))  AT=100
.MEAS AC ABM_200   FIND DB(V(OUT_ABM)) AT=200
.MEAS AC SK_200    FIND DB(V(OUT_SK))  AT=200
.MEAS AC ABM_500   FIND DB(V(OUT_ABM)) AT=500
.MEAS AC SK_500    FIND DB(V(OUT_SK))  AT=500
.MEAS AC ABM_1K    FIND DB(V(OUT_ABM)) AT=1k
.MEAS AC SK_1K     FIND DB(V(OUT_SK))  AT=1k
.MEAS AC ABM_2K    FIND DB(V(OUT_ABM)) AT=2k
.MEAS AC SK_2K     FIND DB(V(OUT_SK))  AT=2k
.MEAS AC ABM_5K    FIND DB(V(OUT_ABM)) AT=5k
.MEAS AC SK_5K     FIND DB(V(OUT_SK))  AT=5k
.MEAS AC ABM_10K   FIND DB(V(OUT_ABM)) AT=10k
.MEAS AC SK_10K    FIND DB(V(OUT_SK))  AT=10k
.MEAS AC ABM_20K   FIND DB(V(OUT_ABM)) AT=20k
.MEAS AC SK_20K    FIND DB(V(OUT_SK))  AT=20k
.MEAS AC ABM_50K   FIND DB(V(OUT_ABM)) AT=50k
.MEAS AC SK_50K    FIND DB(V(OUT_SK))  AT=50k
.MEAS AC ABM_100K  FIND DB(V(OUT_ABM)) AT=100k
.MEAS AC SK_100K   FIND DB(V(OUT_SK))  AT=100k
.PROBE

.END
